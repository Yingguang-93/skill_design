/****************************************************/
/*             Title : 快速切换层叠                  */
/*            Author : tb669                        */
/*     Creation Date : 2015-09-09                   */
/*            Update : 2016-11-01                   */
/*           Version : 1.1                          */
/* 2016-11-01 顶底层布局增加pin number显示          */
/****************************************************/

axlCmdRegister( "20" 'BOTTOM);输入命令为20 调用BOTTOM程序 适用于底层布线
axlCmdRegister( "21" 'TOP)  ;适用于顶层布线
axlCmdRegister( "210" 'place)  ;适用于顶底层布线
axlCmdRegister( "22" 'L2)
axlCmdRegister( "23" 'L3)
axlCmdRegister( "24" 'L4)
axlCmdRegister( "25" 'L5)
axlCmdRegister( "26" 'L6)
axlCmdRegister( "27" 'L7)
axlCmdRegister( "28" 'L8)
axlCmdRegister( "29" 'L9)
axlCmdRegister( "2.0" 'L10)
axlCmdRegister( "2.1" 'L11)
axlCmdRegister( "2.2" 'L12)
axlCmdRegister( "2.3" 'L13)
axlCmdRegister( "2.4" 'L14)
axlCmdRegister( "2.5" 'L15)
axlCmdRegister( "2.6" 'L16)
axlCmdRegister( "200" 'bottomm)    ;适用于底层布局
axlCmdRegister( "211" 'topp)    ;适用于顶层布局
axlCmdRegister( "2100" 'placee)  ;适用于顶底层布局
axlCmdRegister( "st" 'skt)    ;适用于顶层丝印
axlCmdRegister( "sb" 'skb)    ;适用于底层丝印
axlCmdRegister( "stb" 'sktb)   ;适用于顶底层丝印
axlCmdRegister( "art" 'allart)   ;所有光绘层及photooutline

defun( allart ()   ;sktb程序
       axlVisibleDesign(nil) ;关闭所有层
	items = axlGetParam("paramLayerGroup:ETCH")->groupMembers
	sum = length(items)
	foreach(db items
		axlVisibleLayer(sprintf(nil "ETCH/%s" db) t)
		axlVisibleLayer(sprintf(nil "VIA class/%s" db) t)
		axlVisibleLayer(sprintf(nil "PIN/%s" db) t)
	)
       axlVisibleLayer(sprintf(nil "MANUFACTURING/NCLEGEND-1-%d" length(items)) t)
 	axlVisibleLayer( "BOARD GEOMETRY/OUTLINE" t )  ;打开BOARD GEOMETRY/OUTLINE层 BOARD GEOMETRY为class，OUTLINE为subclass
 	axlVisibleLayer( "BOARD GEOMETRY/SILKSCREEN_TOP" t )
	axlVisibleLayer( "PIN/TOP" t )
	axlVisibleLayer( "via class/TOP" t )
	axlVisibleLayer( "etch/TOP" t )
	axlVisibleLayer( "via class/BOTTOM" t )
	axlVisibleLayer( "etch/BOTTOM" t )
	axlVisibleLayer( "REF DES/SILKSCREEN_TOP" t )
	axlVisibleLayer( "PACKAGE GEOMETRY/SILKSCREEN_TOP" t )
	axlVisibleLayer( "PIN/SOLDERMASK_TOP" t )
	axlVisibleLayer( "via class/SOLDERMASK_TOP" t )  ;注意此处正确的class写法为via class 而不是 via
	axlVisibleLayer( "PACKAGE GEOMETRY/SOLDERMASK_TOP" t )
	axlVisibleLayer( "BOARD GEOMETRY/SOLDERMASK_TOP" t )
 	axlVisibleLayer( "BOARD GEOMETRY/SILKSCREEN_BOTTOM" t )
	axlVisibleLayer( "PIN/BOTTOM" t )
	axlVisibleLayer( "REF DES/SILKSCREEN_BOTTOM" t )
	axlVisibleLayer( "PACKAGE GEOMETRY/SILKSCREEN_BOTTOM" t )
	axlVisibleLayer( "PIN/SOLDERMASK_BOTTOM" t )
	axlVisibleLayer( "via class/SOLDERMASK_BOTTOM" t )
	axlVisibleLayer( "PACKAGE GEOMETRY/SOLDERMASK_BOTTOM" t )
	axlVisibleLayer( "BOARD GEOMETRY/SOLDERMASK_BOTTOM" t )
	axlVisibleLayer( "PIN/PASTEMASK_TOP" t )
	axlVisibleLayer( "PIN/PASTEMASK_BOTTOM" t )
	axlVisibleLayer( "PACKAGE GEOMETRY/PASTEMASK_TOP" t )
	axlVisibleLayer( "PACKAGE GEOMETRY/PASTEMASK_BOTTOM" t )
	axlVisibleLayer( "manufacturing/photoplot_outline" t )
	axlVisibleLayer( "manufacturing/NCDRILL_LEGEND" t )
                axlVisibleUpdate(t)) ;刷新显示层

defun( sktb ()   ;sktb程序
       axlVisibleDesign(nil) ;关闭所有层
 	axlVisibleLayer( "BOARD GEOMETRY/OUTLINE" t )  ;打开BOARD GEOMETRY/OUTLINE层 BOARD GEOMETRY为class，OUTLINE为subclass
 	axlVisibleLayer( "BOARD GEOMETRY/SILKSCREEN_TOP" t )
	axlVisibleLayer( "PIN/TOP" t )
	axlVisibleLayer( "REF DES/SILKSCREEN_TOP" t )
	axlVisibleLayer( "PACKAGE GEOMETRY/SILKSCREEN_TOP" t )
	axlVisibleLayer( "PIN/SOLDERMASK_TOP" t )
	axlVisibleLayer( "via class/SOLDERMASK_TOP" t )  ;注意此处正确的class写法为via class 而不是 via
	axlVisibleLayer( "PACKAGE GEOMETRY/SOLDERMASK_TOP" t )
	axlVisibleLayer( "BOARD GEOMETRY/SOLDERMASK_TOP" t )
 	axlVisibleLayer( "BOARD GEOMETRY/SILKSCREEN_BOTTOM" t )
	axlVisibleLayer( "PIN/BOTTOM" t )
	axlVisibleLayer( "REF DES/SILKSCREEN_BOTTOM" t )
	axlVisibleLayer( "PACKAGE GEOMETRY/SILKSCREEN_BOTTOM" t )
	axlVisibleLayer( "PIN/SOLDERMASK_BOTTOM" t )
	axlVisibleLayer( "via class/SOLDERMASK_BOTTOM" t )
	axlVisibleLayer( "PACKAGE GEOMETRY/SOLDERMASK_BOTTOM" t )
	axlVisibleLayer( "BOARD GEOMETRY/SOLDERMASK_BOTTOM" t )
	axlVisibleLayer( "package keepout/top" t )
	axlVisibleLayer( "package keepout/all" t )
	axlVisibleLayer( "package keepout/bottom" t )
	axlVisibleLayer( "PACKAGE GEOMETRY/PASTMASK_TOP" t )
	axlVisibleLayer( "PACKAGE GEOMETRY/PASTMASK_BOTTOM" t )
axlVisibleLayer( "DRC ERROR CLASS/SOLDERMASK_bottom" t )
axlVisibleLayer( "DRC ERROR CLASS/SOLDERMASK_TOP" t )
                axlVisibleUpdate(t)) ;刷新显示层

defun( skb ()
       axlVisibleDesign(nil)
 	axlVisibleLayer( "BOARD GEOMETRY/OUTLINE" t )
 	axlVisibleLayer( "BOARD GEOMETRY/SILKSCREEN_BOTTOM" t )
	axlVisibleLayer( "PIN/BOTTOM" t )
	axlVisibleLayer( "REF DES/SILKSCREEN_BOTTOM" t )
	axlVisibleLayer( "PACKAGE GEOMETRY/SILKSCREEN_BOTTOM" t )
	axlVisibleLayer( "PIN/SOLDERMASK_BOTTOM" t )
	axlVisibleLayer( "via class/SOLDERMASK_BOTTOM" t )
	axlVisibleLayer( "PACKAGE GEOMETRY/SOLDERMASK_BOTTOM" t )
	axlVisibleLayer( "BOARD GEOMETRY/SOLDERMASK_BOTTOM" t )
	axlVisibleLayer( "package keepout/bottom" t )
	axlVisibleLayer( "package keepout/all" t )
axlVisibleLayer( "MANUFACTURING/REFDES bottom DRC" t ) ;此处REFDES bottom DRC为新建层配合丝印错位工具使用 没用可忽略
axlVisibleLayer( "DRC ERROR CLASS/SOLDERMASK_bottom" t )  ;注意此处正确的class写法为DRC ERROR CLASS 而不是 DRC 此层为阻焊间距drc没用可去掉

                axlVisibleUpdate(t))

defun( skt ()
       axlVisibleDesign(nil)
 	axlVisibleLayer( "BOARD GEOMETRY/OUTLINE" t )
 	axlVisibleLayer( "BOARD GEOMETRY/SILKSCREEN_TOP" t )
	axlVisibleLayer( "PIN/TOP" t )
	axlVisibleLayer( "REF DES/SILKSCREEN_TOP" t )
	axlVisibleLayer( "PACKAGE GEOMETRY/SILKSCREEN_TOP" t )
	axlVisibleLayer( "PIN/SOLDERMASK_TOP" t )
	axlVisibleLayer( "via class/SOLDERMASK_TOP" t )
	axlVisibleLayer( "PACKAGE GEOMETRY/SOLDERMASK_TOP" t )
	axlVisibleLayer( "BOARD GEOMETRY/SOLDERMASK_TOP" t )
	axlVisibleLayer( "package keepout/top" t )
	axlVisibleLayer( "package keepout/all" t )
	axlVisibleLayer( "MANUFACTURING/REFDES TOP DRC" t )
axlVisibleLayer( "DRC ERROR CLASS/SOLDERMASK_TOP" t )
                axlVisibleUpdate(t))

defun( topp ()
       axlVisibleDesign(nil)
 	axlVisibleLayer( "BOARD GEOMETRY/OUTLINE" t )
	axlVisibleLayer( "PIN/TOP" t )
	axlVisibleLayer( "VIA class/top" t )
	axlVisibleLayer( "etch/TOP" t )
	axlVisibleLayer( "PACKAGE GEOMETRY/SILKSCREEN_TOP" t )
 	axlVisibleLayer( "BOARD GEOMETRY/SILKSCREEN_TOP" t )
	axlVisibleLayer( "DRC ERROR CLASS/top" t )
	axlVisibleLayer( "package keepout/top" t )
	axlVisibleLayer( "package keepout/all" t )
	axlVisibleLayer( "route keepout/top" t )
	axlVisibleLayer( "route keepout/all" t )
	axlVisibleLayer( "route keepin/all" t )
	axlVisibleLayer( "PACKAGE GEOMETRY/Place_Bound_Top" t )
	axlVisibleLayer( "PACKAGE GEOMETRY/Pin_Number" t )
	axlVisibleLayer( "DRC ERROR CLASS/package_top" t )
	axlVisibleLayer( "PACKAGE keepin/all" t )
                axlVisibleUpdate(t))

defun( bottomm ()
       axlVisibleDesign(nil)
 	axlVisibleLayer( "BOARD GEOMETRY/OUTLINE" t )
	axlVisibleLayer( "PIN/bottom" t )
	axlVisibleLayer( "VIA class/bottom" t )
	axlVisibleLayer( "etch/bottom" t )
	axlVisibleLayer( "PACKAGE GEOMETRY/SILKSCREEN_bottom" t )
 	axlVisibleLayer( "BOARD GEOMETRY/SILKSCREEN_BOTTOM" t )
	axlVisibleLayer( "DRC ERROR CLASS/bottom" t )
	axlVisibleLayer( "package keepout/bottom" t )
	axlVisibleLayer( "package keepout/all" t )
	axlVisibleLayer( "route keepout/bottom" t )
	axlVisibleLayer( "route keepout/all" t )
	axlVisibleLayer( "PACKAGE GEOMETRY/Place_Bound_Bottom" t )
	axlVisibleLayer( "PACKAGE GEOMETRY/Pin_Number" t )
	axlVisibleLayer( "DRC ERROR CLASS/package_bottom" t )
	axlVisibleLayer( "PACKAGE keepin/all" t )
axlVisibleLayer( "route keepin/all" t )
                axlVisibleUpdate(t))

defun( placee ()
       axlVisibleDesign(nil)
 	axlVisibleLayer( "BOARD GEOMETRY/OUTLINE" t )
	axlVisibleLayer( "PIN/bottom" t )
	axlVisibleLayer( "VIA class/bottom" t )
	axlVisibleLayer( "etch/bottom" t )
	axlVisibleLayer( "DRC ERROR CLASS/bottom" t )
	axlVisibleLayer( "package keepout/bottom" t )
	axlVisibleLayer( "package keepout/all" t )
	axlVisibleLayer( "route keepout/bottom" t )
	axlVisibleLayer( "route keepout/all" t )
	axlVisibleLayer( "BOARD GEOMETRY/OUTLINE" t )
	axlVisibleLayer( "PIN/TOP" t )
	axlVisibleLayer( "VIA class/top" t )
	axlVisibleLayer( "etch/TOP" t )
	axlVisibleLayer( "PACKAGE GEOMETRY/SILKSCREEN_TOP" t )
	axlVisibleLayer( "PACKAGE GEOMETRY/SILKSCREEN_bottom" t )
	axlVisibleLayer( "PACKAGE GEOMETRY/Pin_Number" t )
 	axlVisibleLayer( "BOARD GEOMETRY/SILKSCREEN_BOTTOM" t )
 	axlVisibleLayer( "BOARD GEOMETRY/SILKSCREEN_TOP" t )
	axlVisibleLayer( "DRC ERROR CLASS/top" t )
	axlVisibleLayer( "package keepout/top" t )
	axlVisibleLayer( "package keepout/all" t )
	axlVisibleLayer( "route keepout/top" t )
	axlVisibleLayer( "route keepout/all" t )
	axlVisibleLayer( "route keepin/all" t )
	axlVisibleLayer( "package keepin/all" t )
	axlVisibleLayer( "PACKAGE GEOMETRY/place_bound_bottom" t )
	axlVisibleLayer( "DRC ERROR CLASS/package_bottom" t )
	axlVisibleLayer( "PACKAGE GEOMETRY/place_bound_top" t )
	axlVisibleLayer( "DRC ERROR CLASS/package_top" t )
	axlVisibleLayer( "manufacturing/pen24" t )  ;此行及下面两行为导入结构可能所在层可根据个人习惯增减
	axlVisibleLayer( "manufacturing/pen57" t )
	axlVisibleLayer( "manufacturing/photoplot_outline" t )
 	axlVisibleLayer( "BOARD GEOMETRY/Dimension" t )
                axlVisibleUpdate(t))

defun( BOTTOM ()
axlVisibleDesign(nil)
axlVisibleLayer( "BOARD GEOMETRY/OUTLINE" t )
axlVisibleLayer( "PIN/bottom" t )
axlVisibleLayer( "VIA class/bottom" t )
axlVisibleLayer( "etch/bottom" t )
axlVisibleLayer( "PACKAGE GEOMETRY/SILKSCREEN_bottom" t )
axlVisibleLayer( "DRC ERROR CLASS/bottom" t )
axlVisibleLayer( "package keepout/bottom" t )
axlVisibleLayer( "package keepout/all" t )
axlVisibleLayer( "route keepout/bottom" t )
axlVisibleLayer( "route keepout/all" t )
axlVisibleLayer( "PACKAGE keepin/all" t )
axlVisibleLayer( "route keepin/all" t )
axlVisibleUpdate(t)
axlSetActiveLayer( "etch/bottom")
)

defun( place ()
       axlVisibleDesign(nil)
 	axlVisibleLayer( "BOARD GEOMETRY/OUTLINE" t )
	axlVisibleLayer( "PIN/bottom" t )
	axlVisibleLayer( "VIA class/bottom" t )
	axlVisibleLayer( "etch/bottom" t )
	axlVisibleLayer( "DRC ERROR CLASS/bottom" t )
	axlVisibleLayer( "package keepout/bottom" t )
	axlVisibleLayer( "package keepout/all" t )
	axlVisibleLayer( "route keepout/bottom" t )
	axlVisibleLayer( "route keepout/all" t )
	axlVisibleLayer( "BOARD GEOMETRY/OUTLINE" t )
	axlVisibleLayer( "PIN/TOP" t )
	axlVisibleLayer( "VIA class/top" t )
	axlVisibleLayer( "etch/TOP" t )
	axlVisibleLayer( "PACKAGE GEOMETRY/SILKSCREEN_TOP" t )
	axlVisibleLayer( "PACKAGE GEOMETRY/SILKSCREEN_bottom" t )
	axlVisibleLayer( "DRC ERROR CLASS/top" t )
	axlVisibleLayer( "package keepout/top" t )
	axlVisibleLayer( "package keepout/all" t )
	axlVisibleLayer( "route keepout/top" t )
	axlVisibleLayer( "route keepout/all" t )
	axlVisibleLayer( "route keepin/all" t )
	axlVisibleLayer( "package keepin/all" t )
	;axlVisibleLayer( "PACKAGE GEOMETRY/place_bound_bottom" t )
	;axlVisibleLayer( "DRC ERROR CLASS/package_bottom" t )
	;axlVisibleLayer( "PACKAGE GEOMETRY/place_bound_top" t )
	;axlVisibleLayer( "DRC ERROR CLASS/package_top" t )
	;axlVisibleLayer( "manufacturing/pen24" t )
                axlVisibleUpdate(t))

defun( TOP ()
axlVisibleDesign(nil)
axlVisibleLayer( "BOARD GEOMETRY/OUTLINE" t )
axlVisibleLayer( "PIN/TOP" t )
axlVisibleLayer( "VIA class/top" t )
axlVisibleLayer( "etch/TOP" t )
axlVisibleLayer( "PACKAGE GEOMETRY/SILKSCREEN_TOP" t )
axlVisibleLayer( "DRC ERROR CLASS/top" t )
axlVisibleLayer( "package keepout/top" t )
axlVisibleLayer( "package keepout/all" t )
axlVisibleLayer( "route keepout/top" t )
axlVisibleLayer( "route keepout/all" t )
axlVisibleLayer( "route keepin/all" t )
axlVisibleLayer( "PACKAGE keepin/all" t )
axlVisibleUpdate(t)
axlSetActiveLayer( "etch/Top")
)

defun( L2 (@optional (layer "")) ;预留位置
layer = 2 ;设置变量
allLayer = axlGetParam("paramLayerGroup:ETCH")->groupMembers  ;将板中所有层以数组形式存在allLayer中
axlVisibleDesign(nil)
axlVisibleLayer(strcat("ETCH/" nthelem(layer allLayer)) t)  ;strcat组合字符串 nthelem(layer allLayer) 使用数组allLayer的第layer = 2个参数即第二个布线层的名称
axlVisibleLayer(strcat("anti ETCH/" nthelem(layer allLayer)) t)
axlVisibleLayer(strcat("PIN/" nthelem(layer allLayer)) t)
axlVisibleLayer(strcat("VIA CLASS/" nthelem(layer allLayer)) t)
axlVisibleLayer(strcat("DRC ERROR CLASS/" nthelem(layer allLayer)) t)
axlVisibleLayer(strcat("route keepout/" nthelem(layer allLayer)) t)
axlVisibleLayer( "BOARD GEOMETRY/OUTLINE" t )
axlVisibleLayer( "route keepout/all" t )
axlVisibleLayer( "route keepin/all" t )
axlVisibleUpdate(t)
axlSetActiveLayer(strcat("ETCH/" nthelem(layer allLayer)))
)

defun( L3 (@optional (layer ""))
layer = 3
allLayer = axlGetParam("paramLayerGroup:ETCH")->groupMembers
axlVisibleDesign(nil)
axlVisibleLayer(strcat("ETCH/" nthelem(layer allLayer)) t)
axlVisibleLayer(strcat("anti ETCH/" nthelem(layer allLayer)) t)
axlVisibleLayer(strcat("PIN/" nthelem(layer allLayer)) t)
axlVisibleLayer(strcat("VIA CLASS/" nthelem(layer allLayer)) t)
axlVisibleLayer(strcat("DRC ERROR CLASS/" nthelem(layer allLayer)) t)
axlVisibleLayer(strcat("route keepout/" nthelem(layer allLayer)) t)
axlVisibleLayer( "BOARD GEOMETRY/OUTLINE" t )
axlVisibleLayer( "route keepout/all" t )
axlVisibleLayer( "route keepin/all" t )
axlVisibleUpdate(t)
axlSetActiveLayer(strcat("ETCH/" nthelem(layer allLayer)))
)

defun( L4 (@optional (layer ""))
layer = 4
allLayer = axlGetParam("paramLayerGroup:ETCH")->groupMembers
axlVisibleDesign(nil)
axlVisibleLayer(strcat("ETCH/" nthelem(layer allLayer)) t)
axlVisibleLayer(strcat("anti ETCH/" nthelem(layer allLayer)) t)
axlVisibleLayer(strcat("PIN/" nthelem(layer allLayer)) t)
axlVisibleLayer(strcat("VIA CLASS/" nthelem(layer allLayer)) t)
axlVisibleLayer(strcat("DRC ERROR CLASS/" nthelem(layer allLayer)) t)
axlVisibleLayer(strcat("route keepout/" nthelem(layer allLayer)) t)
axlVisibleLayer( "BOARD GEOMETRY/OUTLINE" t )
axlVisibleLayer( "route keepout/all" t )
axlVisibleLayer( "route keepin/all" t )
axlVisibleUpdate(t)
axlSetActiveLayer(strcat("ETCH/" nthelem(layer allLayer)))
)

defun( L5 (@optional (layer ""))
layer = 5
allLayer = axlGetParam("paramLayerGroup:ETCH")->groupMembers
axlVisibleDesign(nil)
axlVisibleLayer(strcat("ETCH/" nthelem(layer allLayer)) t)
axlVisibleLayer(strcat("anti ETCH/" nthelem(layer allLayer)) t)
axlVisibleLayer(strcat("PIN/" nthelem(layer allLayer)) t)
axlVisibleLayer(strcat("VIA CLASS/" nthelem(layer allLayer)) t)
axlVisibleLayer(strcat("DRC ERROR CLASS/" nthelem(layer allLayer)) t)
axlVisibleLayer(strcat("route keepout/" nthelem(layer allLayer)) t)
axlVisibleLayer( "BOARD GEOMETRY/OUTLINE" t )
axlVisibleLayer( "route keepout/all" t )
axlVisibleLayer( "route keepin/all" t )
axlVisibleUpdate(t)
axlSetActiveLayer(strcat("ETCH/" nthelem(layer allLayer)))
)

defun( L6 (@optional (layer ""))
layer = 6
allLayer = axlGetParam("paramLayerGroup:ETCH")->groupMembers
axlVisibleDesign(nil)
axlVisibleLayer(strcat("ETCH/" nthelem(layer allLayer)) t)
axlVisibleLayer(strcat("anti ETCH/" nthelem(layer allLayer)) t)
axlVisibleLayer(strcat("PIN/" nthelem(layer allLayer)) t)
axlVisibleLayer(strcat("VIA CLASS/" nthelem(layer allLayer)) t)
axlVisibleLayer(strcat("DRC ERROR CLASS/" nthelem(layer allLayer)) t)
axlVisibleLayer(strcat("route keepout/" nthelem(layer allLayer)) t)
axlVisibleLayer( "BOARD GEOMETRY/OUTLINE" t )
axlVisibleLayer( "route keepout/all" t )
axlVisibleLayer( "route keepin/all" t )
axlVisibleUpdate(t)
axlSetActiveLayer(strcat("ETCH/" nthelem(layer allLayer)))
)

defun( L7 (@optional (layer ""))
layer = 7
allLayer = axlGetParam("paramLayerGroup:ETCH")->groupMembers
axlVisibleDesign(nil)
axlVisibleLayer(strcat("ETCH/" nthelem(layer allLayer)) t)
axlVisibleLayer(strcat("anti ETCH/" nthelem(layer allLayer)) t)
axlVisibleLayer(strcat("PIN/" nthelem(layer allLayer)) t)
axlVisibleLayer(strcat("VIA CLASS/" nthelem(layer allLayer)) t)
axlVisibleLayer(strcat("DRC ERROR CLASS/" nthelem(layer allLayer)) t)
axlVisibleLayer(strcat("route keepout/" nthelem(layer allLayer)) t)
axlVisibleLayer( "BOARD GEOMETRY/OUTLINE" t )
axlVisibleLayer( "route keepout/all" t )
axlVisibleLayer( "route keepin/all" t )
axlVisibleUpdate(t)
axlSetActiveLayer(strcat("ETCH/" nthelem(layer allLayer)))
)

defun( L8 (@optional (layer ""))
layer = 8
allLayer = axlGetParam("paramLayerGroup:ETCH")->groupMembers
axlVisibleDesign(nil)
axlVisibleLayer(strcat("ETCH/" nthelem(layer allLayer)) t)
axlVisibleLayer(strcat("anti ETCH/" nthelem(layer allLayer)) t)
axlVisibleLayer(strcat("PIN/" nthelem(layer allLayer)) t)
axlVisibleLayer(strcat("VIA CLASS/" nthelem(layer allLayer)) t)
axlVisibleLayer(strcat("DRC ERROR CLASS/" nthelem(layer allLayer)) t)
axlVisibleLayer(strcat("route keepout/" nthelem(layer allLayer)) t)
axlVisibleLayer( "BOARD GEOMETRY/OUTLINE" t )
axlVisibleLayer( "route keepout/all" t )
axlVisibleLayer( "route keepin/all" t )
axlVisibleUpdate(t)
axlSetActiveLayer(strcat("ETCH/" nthelem(layer allLayer)))
)

defun( L9 (@optional (layer ""))
layer = 9
allLayer = axlGetParam("paramLayerGroup:ETCH")->groupMembers
axlVisibleDesign(nil)
axlVisibleLayer(strcat("ETCH/" nthelem(layer allLayer)) t)
axlVisibleLayer(strcat("anti ETCH/" nthelem(layer allLayer)) t)
axlVisibleLayer(strcat("PIN/" nthelem(layer allLayer)) t)
axlVisibleLayer(strcat("VIA CLASS/" nthelem(layer allLayer)) t)
axlVisibleLayer(strcat("DRC ERROR CLASS/" nthelem(layer allLayer)) t)
axlVisibleLayer(strcat("route keepout/" nthelem(layer allLayer)) t)
axlVisibleLayer( "BOARD GEOMETRY/OUTLINE" t )
axlVisibleLayer( "route keepout/all" t )
axlVisibleLayer( "route keepin/all" t )
axlVisibleUpdate(t)
axlSetActiveLayer(strcat("ETCH/" nthelem(layer allLayer)))
)

defun( L10 (@optional (layer ""))
layer = 10
allLayer = axlGetParam("paramLayerGroup:ETCH")->groupMembers
axlVisibleDesign(nil)
axlVisibleLayer(strcat("ETCH/" nthelem(layer allLayer)) t)
axlVisibleLayer(strcat("anti ETCH/" nthelem(layer allLayer)) t)
axlVisibleLayer(strcat("PIN/" nthelem(layer allLayer)) t)
axlVisibleLayer(strcat("VIA CLASS/" nthelem(layer allLayer)) t)
axlVisibleLayer(strcat("DRC ERROR CLASS/" nthelem(layer allLayer)) t)
axlVisibleLayer(strcat("route keepout/" nthelem(layer allLayer)) t)
axlVisibleLayer( "BOARD GEOMETRY/OUTLINE" t )
axlVisibleLayer( "route keepout/all" t )
axlVisibleLayer( "route keepin/all" t )
axlVisibleUpdate(t)
axlSetActiveLayer(strcat("ETCH/" nthelem(layer allLayer)))
)

defun( L11 (@optional (layer ""))
layer = 11
allLayer = axlGetParam("paramLayerGroup:ETCH")->groupMembers
axlVisibleDesign(nil)
axlVisibleLayer(strcat("ETCH/" nthelem(layer allLayer)) t)
axlVisibleLayer(strcat("anti ETCH/" nthelem(layer allLayer)) t)
axlVisibleLayer(strcat("PIN/" nthelem(layer allLayer)) t)
axlVisibleLayer(strcat("VIA CLASS/" nthelem(layer allLayer)) t)
axlVisibleLayer(strcat("DRC ERROR CLASS/" nthelem(layer allLayer)) t)
axlVisibleLayer(strcat("route keepout/" nthelem(layer allLayer)) t)
axlVisibleLayer( "BOARD GEOMETRY/OUTLINE" t )
axlVisibleLayer( "route keepout/all" t )
axlVisibleLayer( "route keepin/all" t )
axlVisibleUpdate(t)
axlSetActiveLayer(strcat("ETCH/" nthelem(layer allLayer)))
)

defun( L12 (@optional (layer ""))
layer = 12
allLayer = axlGetParam("paramLayerGroup:ETCH")->groupMembers
axlVisibleDesign(nil)
axlVisibleLayer(strcat("ETCH/" nthelem(layer allLayer)) t)
axlVisibleLayer(strcat("anti ETCH/" nthelem(layer allLayer)) t)
axlVisibleLayer(strcat("PIN/" nthelem(layer allLayer)) t)
axlVisibleLayer(strcat("VIA CLASS/" nthelem(layer allLayer)) t)
axlVisibleLayer(strcat("DRC ERROR CLASS/" nthelem(layer allLayer)) t)
axlVisibleLayer(strcat("route keepout/" nthelem(layer allLayer)) t)
axlVisibleLayer( "BOARD GEOMETRY/OUTLINE" t )
axlVisibleLayer( "route keepout/all" t )
axlVisibleLayer( "route keepin/all" t )
axlVisibleUpdate(t)
axlSetActiveLayer(strcat("ETCH/" nthelem(layer allLayer)))
)

defun( L13 (@optional (layer ""))
layer = 13
allLayer = axlGetParam("paramLayerGroup:ETCH")->groupMembers
axlVisibleDesign(nil)
axlVisibleLayer(strcat("ETCH/" nthelem(layer allLayer)) t)
axlVisibleLayer(strcat("anti ETCH/" nthelem(layer allLayer)) t)
axlVisibleLayer(strcat("PIN/" nthelem(layer allLayer)) t)
axlVisibleLayer(strcat("VIA CLASS/" nthelem(layer allLayer)) t)
axlVisibleLayer(strcat("DRC ERROR CLASS/" nthelem(layer allLayer)) t)
axlVisibleLayer(strcat("route keepout/" nthelem(layer allLayer)) t)
axlVisibleLayer( "BOARD GEOMETRY/OUTLINE" t )
axlVisibleLayer( "route keepout/all" t )
axlVisibleLayer( "route keepin/all" t )
axlVisibleUpdate(t)
axlSetActiveLayer(strcat("ETCH/" nthelem(layer allLayer)))
)

defun( L14 (@optional (layer ""))
layer = 14
allLayer = axlGetParam("paramLayerGroup:ETCH")->groupMembers
axlVisibleDesign(nil)
axlVisibleLayer(strcat("ETCH/" nthelem(layer allLayer)) t)
axlVisibleLayer(strcat("anti ETCH/" nthelem(layer allLayer)) t)
axlVisibleLayer(strcat("PIN/" nthelem(layer allLayer)) t)
axlVisibleLayer(strcat("VIA CLASS/" nthelem(layer allLayer)) t)
axlVisibleLayer(strcat("DRC ERROR CLASS/" nthelem(layer allLayer)) t)
axlVisibleLayer(strcat("route keepout/" nthelem(layer allLayer)) t)
axlVisibleLayer( "BOARD GEOMETRY/OUTLINE" t )
axlVisibleLayer( "route keepout/all" t )
axlVisibleLayer( "route keepin/all" t )
axlVisibleUpdate(t)
axlSetActiveLayer(strcat("ETCH/" nthelem(layer allLayer)))
)

defun( L15 (@optional (layer ""))
layer = 15
allLayer = axlGetParam("paramLayerGroup:ETCH")->groupMembers
axlVisibleDesign(nil)
axlVisibleLayer(strcat("ETCH/" nthelem(layer allLayer)) t)
axlVisibleLayer(strcat("anti ETCH/" nthelem(layer allLayer)) t)
axlVisibleLayer(strcat("PIN/" nthelem(layer allLayer)) t)
axlVisibleLayer(strcat("VIA CLASS/" nthelem(layer allLayer)) t)
axlVisibleLayer(strcat("DRC ERROR CLASS/" nthelem(layer allLayer)) t)
axlVisibleLayer(strcat("route keepout/" nthelem(layer allLayer)) t)
axlVisibleLayer( "BOARD GEOMETRY/OUTLINE" t )
axlVisibleLayer( "route keepout/all" t )
axlVisibleLayer( "route keepin/all" t )
axlVisibleUpdate(t)
axlSetActiveLayer(strcat("ETCH/" nthelem(layer allLayer)))
)

defun( L16 (@optional (layer ""))
layer = 16
allLayer = axlGetParam("paramLayerGroup:ETCH")->groupMembers
axlVisibleDesign(nil)
axlVisibleLayer(strcat("ETCH/" nthelem(layer allLayer)) t)
axlVisibleLayer(strcat("anti ETCH/" nthelem(layer allLayer)) t)
axlVisibleLayer(strcat("PIN/" nthelem(layer allLayer)) t)
axlVisibleLayer(strcat("VIA CLASS/" nthelem(layer allLayer)) t)
axlVisibleLayer(strcat("DRC ERROR CLASS/" nthelem(layer allLayer)) t)
axlVisibleLayer(strcat("route keepout/" nthelem(layer allLayer)) t)
axlVisibleLayer( "BOARD GEOMETRY/OUTLINE" t )
axlVisibleLayer( "route keepout/all" t )
axlVisibleLayer( "route keepin/all" t )
axlVisibleUpdate(t)
axlSetActiveLayer(strcat("ETCH/" nthelem(layer allLayer)))
)
